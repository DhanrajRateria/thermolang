* ThermoLang Generated SPICE Netlist for Ising Model
* Problem: ising_2x2
* Spins: 4

.title Ising Model Annealing Circuit

* --- Coupling Resistors (J_ij) ---
R0_1 N0 N1 1000.00
R0_3 N0 N3 1000.00
R1_2 N1 N2 1000.00
R2_3 N2 N3 1000.00

* --- Local Field Current Sources (h_i) ---
I0 0 N0 DC 2.5000e-07
I1 0 N1 DC 2.5000e-07
I2 0 N2 DC 2.5000e-07
I3 0 N3 DC 2.5000e-07

* --- Node Capacitors (for stability) & Noise Sources ---
C0 N0 0 1nF
Rnoise0 N0 N_noise_in0 1
Vnoise0 N_noise_in0 0 DC 0
C1 N1 0 1nF
Rnoise1 N1 N_noise_in1 1
Vnoise1 N_noise_in1 0 DC 0
C2 N2 0 1nF
Rnoise2 N2 N_noise_in2 1
Vnoise2 N_noise_in2 0 DC 0
C3 N3 0 1nF
Rnoise3 N3 N_noise_in3 1
Vnoise3 N_noise_in3 0 DC 0

* --- Analysis Directives ---
.TRAN 1us 100ms UIC
* To run noise analysis, uncomment the line below and specify an output node.
*.NOISE V(N0) Vnoise0 dec 10 1 100MEG
* A simple temperature sweep from high to low temp.
.TEMP 100 25 0

.END
